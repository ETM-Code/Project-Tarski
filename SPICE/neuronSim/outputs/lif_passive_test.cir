* Passive LIF Neuron Test
* Generated by lif_neuron_generator_passive.py

.include outputs/lif_passive_passive.subckt

* Power supplies
Vdd vdd 0 DC 5.0
Vref vref 0 DC 2.5

* Neuron instance
* Pins: mem vref vdd comp_pulse sum
Xneuron mem vref vdd comp_pulse sum lif_passive_passive

* Constant current input (into sum/membrane node)
Iin 0 sum DC 1e-6

* Initial conditions (membrane at Vref)
.ic V(mem)=2.5

* Transient analysis
.tran 1e-06 0.05 0 1e-06

* Save data
.control
run
wrdata outputs/passive_output.csv v(mem) v(comp_pulse)
.endc

.end
